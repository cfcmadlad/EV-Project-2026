* flying capacitor link flying_capacitor_s0_p2: two 50 % phases, DC sources with series R0
VA ai 0 3.78944810251
RA ai n1 0.0115760701289
VB bi n1 3.74034740224
RB bi n2 0.0115760701289
C1 cp cx 0.01 ic=3.78944810251
RE cx cm 0.005
S1A cp n1 g1 0 SWF
S1B cm 0 g1 0 SWF
S2A cp n2 g2 0 SWF
S2B cm n1 g2 0 SWF
VG1 g1 0 PULSE(0 1 0 1e-07 1e-07 4.99e-05 0.0001)
BG2 g2 0 V=1-V(g1)
.model SWF SW(Ron=0.01 Roff=1000000 Vt=0.5 Vh=0)
.options plotwinsize=0 numdgt=15 reltol=0.0001
.save I(VA) I(VB) I(C1) I(S1A) I(S1B) I(S2A) I(S2B) V(cp)
.tran 0 0.036 0 2.5e-07 uic
.end
